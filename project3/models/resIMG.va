//resistance model to check "for loop" issue
//Juan Duarte, jpduarte@berkeley.edu

`include "bsimimg_sp_new.include"

module resimg(p,n);
inout p,n;
electrical p,n;

parameter real r=0 from [0:inf);
parameter real L=0 from [0:inf);
parameter real EOT1=0 from [0:inf);
parameter real EOT2=0 from [0:inf);
parameter real TSI=0 from [0:inf);

real Vx;

real vgfb1, vgfb2;

//new core
real k1,k2,A0,xg1,xg2,PHISsat,xg1g,deltaPHISsat,phifguess;
real g,dg1,dg2,dg3,f,df;
integer max_itr_NR,flag_loop,j;
real deltaold,delta;
real q2,phi2;
real phifsnew,phibsnew;
real phifdnew,phibdnew;
real qfronts,qfrontd,qbacks,qbackd;
real alphad,alphas;
real deltanr,abscri;
real factortransition;
real PHISsatline,PHISsatline0;
real factordelta;
real Vphisline,dphidxg1;
real qtots,qtotd, ebs, ebd,eba;

real phibaux;

//Newton method variables
real q,q1,dq2,qsqrt,dqsqrt,dlogsinhqsq;
real dq,qcoth,dqcoth,dqcothqdqsqrt;
real sinhqsq, dsinhqsq,qsqoversinhqsq,logsinhqsq,dqsqoversinhqsq,dlogsinhqsqdqsqrt;
real aaux,baux,caux,daux,eaux,daaux,dbaux,dcaux,ddaux,deaux;
real phi1;

//
real nVtm,cox1,cox2,csi,epssi, ni,epsratio;

real dq1,dq2,aux1;

`define q       1.60219e-19 // Coulombs
`define EPS0        8.85418e-12 // F / m
`define KboQ        8.61708e-5  // Joule / degree
// Numerical Constants
`define EXPL_THRESHOLD  80.0
`define MAX_EXPL    5.540622384e+34
`define MIN_EXPL    1.804851387e-35
`define N_MINLOG    1.0e-38
`define DELTA_1     0.02
`define CONSTCtoK   (273.15)
`define REFTEMP     (300.15) /* 27 degrees C */

// Clamped exponential function
    analog function real lexp;
        input x;
        real x;

     begin
            if(x > `EXPL_THRESHOLD) begin
                lexp = `MAX_EXPL * (1.0+(x)-`EXPL_THRESHOLD);
            end else if(x < -`EXPL_THRESHOLD) begin
                lexp = `MIN_EXPL;
            end else begin
             lexp = exp(x);
            end
            end
    endfunction

// Clamped log function
    analog function real lln;
        input x;
        real x;

        begin
            lln = ln(max(x , `N_MINLOG));
        end
    endfunction

// Hyperbolic smoothing function
    analog function real hypsmooth;
        input x , c;
        real x , c;

        begin
            hypsmooth = 0.5 * (x + sqrt(x*x + 4*c*c));
        end
    endfunction

// Hyperbolic smooth max function
    analog function real hypmax;
        input   x , xmin, c;
        real x , xmin, c;

        begin
            hypmax  =  xmin + 0.5 * (x-xmin-c + sqrt((x-xmin-c)*(x-xmin-c)-4*xmin*c));
        end
    endfunction

//cot
    analog function real cot;
        input x;
        real x;

        begin
            cot = 1/tan(x);
        end
    endfunction

//coth
    analog function real coth;
        input x;
        real x;

        begin
            coth = 1/tanh(x);
        end
    endfunction

//connectingfx
    analog function real connectingfx;
        input a, b, c;
        real a, b, c;

        begin
            connectingfx = a+b-0.5*(a+b-sqrt((a-b)*(a-b)+c));
        end
    endfunction

//connectingfx2
    analog function real connectingfx2;
        input a, b, c;
        real a, b, c;

        begin
            if (a>0) begin
                connectingfx2 = 1.0/pow(pow(1.0/a,c)+pow(1.0/b,c),1.0/c);
            end else begin
                connectingfx2 = a;
            end
            //connectingfx2 = //0.5*(a+b-sqrt((a-b)*(a-b)+c));
        end
    endfunction

    analog function real connectingfx3;
        input a, b, c;
        real a, b, c;

        begin
            connectingfx3 = 0.5*(a+b-sqrt((a-b)*(a-b)+c));
        end
    endfunction

analog begin
    V(p,n) <+ r*I(p,n);

    Vx = V(p,n);

    epssi =11.7* `EPS0;
    nVtm = 0.0259;
    ni = 1e10*1e6;
    Eg= 1.07509;

    cox1        = 3.9 * `EPS0 / EOT1;
    cox2        = 3.9 * `EPS0 / EOT2;
    csi         = epssi / TSI;
    epsratio    = 11.7 / 3.9;

//////////////////////////////////////////////////////////////////////////////////////////////////////////////
    // --------------------------------------------------------
    //   Source End Surface Potential and Charge Calculation : NEW CORE
    // --------------------------------------------------------
    //////////////////////////////////////////////////////////////////////////////////////////////////////////////
    vgfb1eff = Vx;
    vgfb2 = 2.0;

    A0  = (2.0*`q*ni*TSI*TSI)/(epssi*nVtm);
    k1  = cox1/csi;
    k2  = cox2/csi;
    xg1 = vgfb1eff/nVtm;//vgfb1 /nVtm;//
    xg2 = (vgfb2)/nVtm;//vgfb2 /nVtm;//

    //xg1 = connectingfx(xg1,xg1min,5.0);
    //1. saturation potential calculation
    PHISsat = Eg*0.6/nVtm; //TODO: maybe use previous implementation PHISsat? check this
    //xg1g = connectingfx(xg1,PHISsat,0.002);//clamping of x1 for sat potential calculation only, TODO: check if this is a good idea
    xg1g = xg1;
    q1 = xg1g-PHISsat;
    `bsimimg_sp_phissat(surfsat,PHISsat,k1,xg1g,A0,g,dg1,dg2,dg3,PHISsat)
    if (abs(g)>1.0e-10) begin
        `bsimimg_sp_phissat(surfsat1,PHISsat,k1,xg1g,A0,g,dg1,dg2,dg3,PHISsat)
            if (abs(g)>1.0e-10) begin
                `bsimimg_sp_phissat(surfsat2,PHISsat,k1,xg1g,A0,g,dg1,dg2,dg3,PHISsat)
                if (abs(g)>1.0e-10) begin
                    `bsimimg_sp_phissat(surfsat3,PHISsat,k1,xg1g,A0,g,dg1,dg2,dg3,PHISsat)
                end
            end
    end
    phisats = PHISsat*nVtm;
    //2. initial guess for front potential
    `bsimimg_sp_guess(GUESSS,TSI,epsratio,EOT1,EOT2,xg1,xg2,nVtm,PHISsat,phifguess,phibguess)

    qicoreguess = k1*(xg1-phifguess)+k2*(xg2-phibguess);

    phisguesss = phifguess*nVtm;
    phi1 = phifguess;

    `include "potential_iteration_new.include"

    //
    phi1aux1s = phi1aux1;
    phi1aux2s = phi1aux2;
    phi1aux3s = phi1aux3;
    phi1aux4s = phi1aux4;
    phi1aux5s = phi1aux5;

    deltaaux1s = deltaaux1;
    deltaaux2s = deltaaux2;
    deltaaux3s = deltaaux3;
    deltaaux4s = deltaaux4;
    deltaaux5s = deltaaux5;

    qsqrt1s = qsqrt1;
    qsqrt2s = qsqrt2;
    qsqrt3s = qsqrt3;
    qsqrt4s = qsqrt4;
    qsqrt5s = qsqrt5;

    f1s= f1;
    f2s=f2;
    f3s=f3;
    f4s=f4;
    f5s=f5;

    df1s = df1;

    df1saux = 0;//df1aux;

    xg1s= xg1;
    xg2s= xg2;

    phi1newmodel = phi1*nVtm;
    qicores = qicore;
    phifsnew = phi1*nVtm;
    phibsnew = phi2*nVtm;
    qfronts=(xg1-phi1)*cox1*nVtm;
    qbacks=(xg2-phi2)*cox2*nVtm;
    qtots=qfronts+qbacks;
    alphas = qsqrt*(nVtm*nVtm/(TSI*TSI));
    qicores2 = (`q*ni/(nVtm*csi))*(TSI*nVtm/(phifsnew-phibsnew))*exp(phibsnew/nVtm)*(1.0-exp((phifsnew-phibsnew)/nVtm));

    dq1 = ddx(phifsnew,V(p));
    dq2 = ddx(phifguess,V(p));
end

endmodule
