//ferroelectric model
//Juan Pablo Duarte, jpduarte@berkeley.edu July 2016

module fecm(n,p);
inout p,n;
electrical p,n;
electrical N1;

parameter real r=2 from [0:inf);
parameter real area=1e-12 from [0:inf);
parameter real t_FE=1e-9 from [0:inf);
parameter real alpha1_P=-1 from (-inf:inf);
parameter real alpha11_P=0.0 from (-inf:inf);
parameter real alpha111_P=0.0 from (-inf:inf);

real a0ncfet,b0ncfet,c0ncfet,Qfe,Pfe,Vfe,Ife,Efe,Ufe;

analog begin
    a0ncfet = 2.0*alpha1_P*t_FE;
    b0ncfet = 4.0*alpha11_P*t_FE*pow(1,3);
    c0ncfet = 6.0*alpha111_P*t_FE*pow(1,5);

    I(p,n)<+ area*r*ddt(V(N1));
    //V(p,n) <+ r*I(p,n)+(a0*V(N1)+b0*pow(V(N1),3.0));
    I(N1) <+ V(p,n)-r*I(p,n) -(a0ncfet*V(N1)+b0ncfet*pow(V(N1),3.0)+c0ncfet*pow(V(N1),5.0));
    Qfe=V(N1)*area;
    Pfe=Qfe/area;
    Vfe=r*I(p,n) +(a0ncfet*V(N1)+b0ncfet*pow(V(N1),3.0)+c0ncfet*pow(V(N1),5.0));
    Ife=I(p,n);
    Efe = Vfe/t_FE;
    Ufe = (a0ncfet*pow(V(N1),2.0)/2.0+b0ncfet*pow(V(N1),4.0)/4.0+c0ncfet*pow(V(N1),6.0)/6.0)-Qfe*Vfe;
end

endmodule
